** sch_path: /home/ringosinye/eda/projects/ldo-gf180/xschem/caracterizador/charac.sch
**.subckt charac
XM1 VDn VGn GND GND nfet_03v3 L=0.28u W=0.22u nf=1 ad='int((nf+1)/2) * W/nf * 0.18u' as='int((nf+2)/2) * W/nf * 0.18u'
+ pd='2*int((nf+1)/2) * (W/nf + 0.18u)' ps='2*int((nf+2)/2) * (W/nf + 0.18u)' nrd='0.18u / W' nrs='0.18u / W'
+ sa=0 sb=0 sd=0 m=1 par=1
XM2 GND net1 VSp VSp pfet_03v3 L=0.28u W=0.22u nf=1 ad='int((nf+1)/2) * W/nf * 0.18u' as='int((nf+2)/2) * W/nf * 0.18u'
+ pd='2*int((nf+1)/2) * (W/nf + 0.18u)' ps='2*int((nf+2)/2) * (W/nf + 0.18u)' nrd='0.18u / W' nrs='0.18u / W'
+ sa=0 sb=0 sd=0 m=1 par=1
V1 VGn GND 1.8
V2 VDn GND 1.8
V3 VSp GND 1.8
V4 net1 GND 1.8
**** begin user architecture code

.include /home/ringosinye/eda/pdks/gf180mcuD/libs.tech/ngspice/design.ngspice
.lib /home/ringosinye/eda/pdks/gf180mcuD/libs.tech/ngspice/sm141064.ngspice typical

.control
  save all

  * NMOS salida: Id vs Vds, varios Vgs
  dc V2 0 3.3 0.01 V1 0 3.3 0.55
  plot -i(V2) title 'NMOS Output' xlabel 'VDS (V)' ylabel 'ID (A)'

  * NMOS transferencia: Id vs Vgs, varios Vds
  dc V1 0 3.3 0.01 V2 0.55 3.3 0.55
  plot -i(V2) title 'NMOS Transfer' xlabel 'VGS (V)' ylabel 'ID (A)'

  * PMOS salida (V5 = 3.3 fija en la fuente): Vsd = 3.3 - V3
  dc V3 3.3 0 -0.01 V4 3.3 0 -0.55
  plot i(V3) title 'PMOS Output' xlabel 'V3 (V)  [VSD = 3.3 - V3]' ylabel 'ID (A)'

  * PMOS transferencia: Vsg = 3.3 - V4
  dc V4 3.3 0 -0.01 V3 2.75 0 -0.55
  plot i(V3) title 'PMOS Transfer' xlabel 'V4 (V)  [VSG = 3.3 - V4]' ylabel 'ID (A)'
.endc

**** end user architecture code
**.ends
.GLOBAL GND
.end
